* Testbench: VCO_RING free-running oscillation, single point
* Generated from tb_template.spice -- do not hand-edit generated copies
.lib "/home/pocopepe/pdk/volare/sky130/versions/c6d73a35f524070e85faff4a6a9eef49553ebc2b/sky130B/libs.tech/ngspice/sky130.lib.spice" tt

.include "vco_ring.spice"

.temp 27
.param VDD=1.8

Vvdd  vdd  0  DC {VDD}
Vctrl vctrl 0 DC 0.9
Xvco vctrl vdd 0 vout VCO_RING nstages=5 wn_inv=1.0 ln_inv=0.5 wp_inv=2.0 lp_inv=0.5 wcs=2.0 lcs=0.5

.control
  set temp=27
  tran 20p 200n uic
  wrdata ../../results/vco/_sanity/run1.txt v(vout)
  quit
.endc

.end
