* Closed-loop PLL: REF -> PFD -> Charge Pump -> Loop Filter -> VCO -> DIV8 -> back to PFD.
* Design point and rationale: docs/loop_model.md
.lib "__SPICE_MODELS__" tt
.include "/home/pocopepe/code/visualizer/pll-sky130/blocks/pfd/pfd.spice"
.include "/home/pocopepe/code/visualizer/pll-sky130/blocks/divider/divider.spice"
.include "/home/pocopepe/code/visualizer/pll-sky130/blocks/charge_pump/charge_pump.spice"
.include "/home/pocopepe/code/visualizer/pll-sky130/blocks/loop_filter/loop_filter.spice"
.include "/home/pocopepe/code/visualizer/pll-sky130/blocks/vco/vco_ring.spice"

.temp 27
Vdd vdd 0 DC 1.8

* f_ref = 28.275 MHz (period 35.371ns), per docs/loop_model.md
Vref ref 0 PULSE(0 1.8 0 100p 100p 17.686n 35.371n)

Xpfd  ref div_fb up dn vdd 0 PFD
Xcp   up dn vctrl vdd 0 CHARGE_PUMP icp=20u
* Loop filter retuned 2026-10-11: R2 = 3.6k (zeta ~0.70, PM ~65-70 deg at K_VCO = 887 MHz/V).
* The ORIGINAL R2 = 1.7k results (zeta ~0.33) are kept in results/loop/retune/ and
* results/loop/retune_corners/ (R2 = 1.7k / 3.0k / 3.6k runs). See docs/loop_model.md.
Xlf   vctrl 0 LOOP_FILTER r2=3.6k c1=68p c2=6.8p
Xvco  vctrl vdd 0 vco_out VCO_RING nstages=5 wn_inv=1.0 ln_inv=0.5 wp_inv=2.0 lp_inv=0.5 wcs=2.0 lcs=0.5
Xdiv  vco_out div_fb vdd 0 DIV8

* Start away from the nominal 0.9V lock point (but inside the VCO's
* confirmed-oscillating range) to give a real pull-in transient.
* Staggered VCO ring-node ICs per the same fix applied in the standalone
* VCO testbench (avoids synchronous cold-start ringing).
* v(xlf.nlf) MUST be set consistently with v(vctrl), or the loop filter's
* two caps (C1 behind R2, C2 direct) redistribute charge from an
* inconsistent start and vctrl collapses toward (C2*vctrl0)/(C1+C2) before
* the loop ever gets a chance to act -- this was misdiagnosed on the first
* two closed-loop attempts as a digital cold-start glitch (a 50ns charge-
* pump hold was added and did NOT fix it, which is what exposed the real
* cause: the collapse was already happening well within that 50ns window,
* so it couldn't have been the charge pump).
.ic v(vctrl)=0.85 v(xlf.nlf)=0.85 v(xvco.n1)=0 v(xvco.n2)=1.8 v(xvco.n3)=0 v(xvco.n4)=1.8 v(xvco.n5)=0

.tran 20p 2000n uic

.control
  run
  wrdata results_loop.txt v(vctrl) v(vco_out) v(div_fb) v(up) v(dn)
  quit
.endc
.end
