* Passive lead-lag loop filter (type-II, 2nd order dominant + 3rd-order
* ripple pole). Values from the analytical loop model in
* docs/loop_model.md: C1=68p, C2=6.8p (C2=C1/10, standard ripple-pole
* placement). Review 1 documented R2=1.7k as targeting fn~2MHz, zeta~0.72;
* that was an arithmetic error (missing 1/(2*pi) in omega_n^2).
* Corrected 2026-10-11: at Icp=20uA, N=8, local Kvco~887MHz/V (Vctrl=0.9V,
* tt, 27C) the ORIGINAL R2=1.7k gave fn~0.9MHz, zeta~0.33, PM~30-33deg
* (underdamped).
* RETUNED 2026-10-11: R2=3.6k (zeta~0.70, PM~65-70deg, fn unchanged ~0.9MHz),
* verified by transistor-level closed-loop simulation (tt coarse + 0V cold
* start, 5 corners). The testbenches (tb_closed_loop*.spice) now instantiate
* r2=3.6k explicitly. The subckt default below (1.7k) is the ORIGINAL value
* and is left unchanged; original R2=1.7k results are in results/loop/retune/
* and results/loop/retune_corners/.
* See docs/loop_model.md and results/loop/FINDINGS_RETUNE.md.
.subckt LOOP_FILTER vctrl vss
+ r2=1.7k c1=68p c2=6.8p
Rlf  vctrl nlf  {r2}
Clf  nlf   vss  {c1}
C2lf vctrl vss  {c2}
.ends LOOP_FILTER
