* sky130B textbook factorial corners n<N>p<P>, N,P in {s,t,f}. Generated by scripts/make_factorial_lib.py

.lib nsps
.param mc_mm_switch=0
.param mc_pr_switch=0
.include "/home/pocopepe/code/visualizer/pll-sky130/env/factorial/corner_nsps.spice"
.include "/home/pocopepe/pdk/volare/sky130/versions/c6d73a35f524070e85faff4a6a9eef49553ebc2b/sky130B/libs.tech/ngspice/r+c/res_typical__cap_typical.spice"
.include "/home/pocopepe/pdk/volare/sky130/versions/c6d73a35f524070e85faff4a6a9eef49553ebc2b/sky130B/libs.tech/ngspice/r+c/res_typical__cap_typical__lin.spice"
.include "/home/pocopepe/pdk/volare/sky130/versions/c6d73a35f524070e85faff4a6a9eef49553ebc2b/sky130B/libs.tech/ngspice/corners/ss/specialized_cells.spice"
.endl nsps

.lib nspt
.param mc_mm_switch=0
.param mc_pr_switch=0
.include "/home/pocopepe/code/visualizer/pll-sky130/env/factorial/corner_nspt.spice"
.include "/home/pocopepe/pdk/volare/sky130/versions/c6d73a35f524070e85faff4a6a9eef49553ebc2b/sky130B/libs.tech/ngspice/r+c/res_typical__cap_typical.spice"
.include "/home/pocopepe/pdk/volare/sky130/versions/c6d73a35f524070e85faff4a6a9eef49553ebc2b/sky130B/libs.tech/ngspice/r+c/res_typical__cap_typical__lin.spice"
.include "/home/pocopepe/pdk/volare/sky130/versions/c6d73a35f524070e85faff4a6a9eef49553ebc2b/sky130B/libs.tech/ngspice/corners/tt/specialized_cells.spice"
.endl nspt

.lib nspf
.param mc_mm_switch=0
.param mc_pr_switch=0
.include "/home/pocopepe/code/visualizer/pll-sky130/env/factorial/corner_nspf.spice"
.include "/home/pocopepe/pdk/volare/sky130/versions/c6d73a35f524070e85faff4a6a9eef49553ebc2b/sky130B/libs.tech/ngspice/r+c/res_typical__cap_typical.spice"
.include "/home/pocopepe/pdk/volare/sky130/versions/c6d73a35f524070e85faff4a6a9eef49553ebc2b/sky130B/libs.tech/ngspice/r+c/res_typical__cap_typical__lin.spice"
.include "/home/pocopepe/pdk/volare/sky130/versions/c6d73a35f524070e85faff4a6a9eef49553ebc2b/sky130B/libs.tech/ngspice/corners/tt/specialized_cells.spice"
.endl nspf

.lib ntps
.param mc_mm_switch=0
.param mc_pr_switch=0
.include "/home/pocopepe/code/visualizer/pll-sky130/env/factorial/corner_ntps.spice"
.include "/home/pocopepe/pdk/volare/sky130/versions/c6d73a35f524070e85faff4a6a9eef49553ebc2b/sky130B/libs.tech/ngspice/r+c/res_typical__cap_typical.spice"
.include "/home/pocopepe/pdk/volare/sky130/versions/c6d73a35f524070e85faff4a6a9eef49553ebc2b/sky130B/libs.tech/ngspice/r+c/res_typical__cap_typical__lin.spice"
.include "/home/pocopepe/pdk/volare/sky130/versions/c6d73a35f524070e85faff4a6a9eef49553ebc2b/sky130B/libs.tech/ngspice/corners/tt/specialized_cells.spice"
.endl ntps

.lib ntpt
.param mc_mm_switch=0
.param mc_pr_switch=0
.include "/home/pocopepe/code/visualizer/pll-sky130/env/factorial/corner_ntpt.spice"
.include "/home/pocopepe/pdk/volare/sky130/versions/c6d73a35f524070e85faff4a6a9eef49553ebc2b/sky130B/libs.tech/ngspice/r+c/res_typical__cap_typical.spice"
.include "/home/pocopepe/pdk/volare/sky130/versions/c6d73a35f524070e85faff4a6a9eef49553ebc2b/sky130B/libs.tech/ngspice/r+c/res_typical__cap_typical__lin.spice"
.include "/home/pocopepe/pdk/volare/sky130/versions/c6d73a35f524070e85faff4a6a9eef49553ebc2b/sky130B/libs.tech/ngspice/corners/tt/specialized_cells.spice"
.endl ntpt

.lib ntpf
.param mc_mm_switch=0
.param mc_pr_switch=0
.include "/home/pocopepe/code/visualizer/pll-sky130/env/factorial/corner_ntpf.spice"
.include "/home/pocopepe/pdk/volare/sky130/versions/c6d73a35f524070e85faff4a6a9eef49553ebc2b/sky130B/libs.tech/ngspice/r+c/res_typical__cap_typical.spice"
.include "/home/pocopepe/pdk/volare/sky130/versions/c6d73a35f524070e85faff4a6a9eef49553ebc2b/sky130B/libs.tech/ngspice/r+c/res_typical__cap_typical__lin.spice"
.include "/home/pocopepe/pdk/volare/sky130/versions/c6d73a35f524070e85faff4a6a9eef49553ebc2b/sky130B/libs.tech/ngspice/corners/tt/specialized_cells.spice"
.endl ntpf

.lib nfps
.param mc_mm_switch=0
.param mc_pr_switch=0
.include "/home/pocopepe/code/visualizer/pll-sky130/env/factorial/corner_nfps.spice"
.include "/home/pocopepe/pdk/volare/sky130/versions/c6d73a35f524070e85faff4a6a9eef49553ebc2b/sky130B/libs.tech/ngspice/r+c/res_typical__cap_typical.spice"
.include "/home/pocopepe/pdk/volare/sky130/versions/c6d73a35f524070e85faff4a6a9eef49553ebc2b/sky130B/libs.tech/ngspice/r+c/res_typical__cap_typical__lin.spice"
.include "/home/pocopepe/pdk/volare/sky130/versions/c6d73a35f524070e85faff4a6a9eef49553ebc2b/sky130B/libs.tech/ngspice/corners/tt/specialized_cells.spice"
.endl nfps

.lib nfpt
.param mc_mm_switch=0
.param mc_pr_switch=0
.include "/home/pocopepe/code/visualizer/pll-sky130/env/factorial/corner_nfpt.spice"
.include "/home/pocopepe/pdk/volare/sky130/versions/c6d73a35f524070e85faff4a6a9eef49553ebc2b/sky130B/libs.tech/ngspice/r+c/res_typical__cap_typical.spice"
.include "/home/pocopepe/pdk/volare/sky130/versions/c6d73a35f524070e85faff4a6a9eef49553ebc2b/sky130B/libs.tech/ngspice/r+c/res_typical__cap_typical__lin.spice"
.include "/home/pocopepe/pdk/volare/sky130/versions/c6d73a35f524070e85faff4a6a9eef49553ebc2b/sky130B/libs.tech/ngspice/corners/tt/specialized_cells.spice"
.endl nfpt

.lib nfpf
.param mc_mm_switch=0
.param mc_pr_switch=0
.include "/home/pocopepe/code/visualizer/pll-sky130/env/factorial/corner_nfpf.spice"
.include "/home/pocopepe/pdk/volare/sky130/versions/c6d73a35f524070e85faff4a6a9eef49553ebc2b/sky130B/libs.tech/ngspice/r+c/res_typical__cap_typical.spice"
.include "/home/pocopepe/pdk/volare/sky130/versions/c6d73a35f524070e85faff4a6a9eef49553ebc2b/sky130B/libs.tech/ngspice/r+c/res_typical__cap_typical__lin.spice"
.include "/home/pocopepe/pdk/volare/sky130/versions/c6d73a35f524070e85faff4a6a9eef49553ebc2b/sky130B/libs.tech/ngspice/corners/ff/specialized_cells.spice"
.endl nfpf
