* Same as tb_comp_template.spice but with device mismatch enabled
* (mc_mm_switch=1) and a fixed random seed set FIRST, before any analysis --
* verified by isolated test that `set rndseed=X` must be the first .control
* command in its own ngspice process to actually perturb agauss() draws;
* mid-script reseeding within one process does NOT re-draw (same lesson as
* the temperature-substitution issue in tb_template.spice: parse-time-bound
* values need a fresh process, not a runtime command).
.lib "/home/pocopepe/pdk/volare/sky130/versions/c6d73a35f524070e85faff4a6a9eef49553ebc2b/sky130B/libs.tech/ngspice/sky130.lib.spice" tt
.param mc_mm_switch=1

.include "/home/pocopepe/code/visualizer/pll-sky130/blocks/vco/vco_ring.spice"

.temp 85
.param VDD=1.8
.param TSTOP=400n
.param TSKIP=0.5*TSTOP

Vvdd_ideal vdd_i 0 DC {VDD}
Vsense     vdd_i vdd DC 0
Vctrl_nom vctrl_nom 0 DC 0.9
Bcomp vctrl vctrl_nom V = '-1.5426443e-4*(85-27) + 4.1834805e-7*(85-27)*(85-27)'
Xvco vctrl vdd 0 vout VCO_RING nstages=5 wn_inv=1.0 ln_inv=0.5 wp_inv=2.0 lp_inv=0.5 wcs=2.0 lcs=0.5

.ic v(xvco.n1)=0 v(xvco.n2)=1.8 v(xvco.n3)=0 v(xvco.n4)=1.8 v(xvco.n5)=0

.tran 10p {TSTOP} uic
.meas tran i_avg_A avg i(vsense) from={TSKIP} to={TSTOP}

.control
  set rndseed=61
  set temp=85
  run
  wrdata results/mc_v2/tt_T85_k1-1.5426443e-4_k24.1834805e-7_seed61.txt v(vout)
  quit
.endc

.end
